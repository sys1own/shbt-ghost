* LVS Subcircuit Extraction Model for 8x8 InP/InGaAs Cavity Element
.SUBCKT INP_INGAAS_CAVITY_NODE IN_OPT OUT_OPT BIAS_NB GND_CRYOMET
XCAV1 IN_OPT OUT_OPT INP_CAVITY_MODEL AREA=12.5P PITCH=50.0U
L_AIRBRIDGE BIAS_NB INT_NODE L=5.0U W=1.5U R_DC=1.2E-3
R_NB_TRACE INT_NODE CAV_ANODE R_SPEC=0.0 ; Superconducting below 9.20K
D_MQW CAV_ANODE GND_CRYOMET INGAAS_DIODE_MODEL
.MODEL INP_CAVITY_MODEL OPTICAL_RESONATOR N_EFF=3.45 Q_FACTOR=15000
.MODEL INGAAS_DIODE_MODEL D(IS=1E-12 N=1.15 RS=0.05 CJO=120FF)
.ENDS INP_INGAAS_CAVITY_NODE
